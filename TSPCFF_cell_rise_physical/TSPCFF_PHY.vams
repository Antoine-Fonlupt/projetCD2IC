// Mandatory for Cadence IRUN/AMS in order to avoid confusion between
// the  access function Q (charge evaluation) and a port named Q
// should be defined berfore the standard VAMS include files.
//
//
//
//                        LINUX           Thu Nov 20 13:28:27 2025
//
//
//
//   PROGRAM  advgen
//
//   Name           : advgen - Quantus QRC - (64-bit)
//   Version        : 15.2.7-s638
//   Build Date     : Wed Jan  4 18:11:53 PST 2017
//
//   HSPICE LIBRARY
//
//
//
//
module TSPCFF ( VDD , VSS , CK , D , QQ );
  inout       VDD ,  VSS ,  CK ,  D , QQ ;
  //
  //
  //   caps2d version: 10
  //
  //
  //        TRANSISTOR CARDS
  //
  //
  electrical \VSS#3 ;
  electrical \VSS#6 ;
  electrical \CK#2 ;
  electrical \CKb#11 ;
  g45n1svt #( .l(4.5e-08), .w(1.45e-07), .ad(2.03e-14), .as(2.03e-14), .pd(5.7e-07), .ps(5.7e-07), .nrd(3.388E-01), .nrs(3.388E-01), .scc(0.000309076), .scb(0.0131402), .sca(12.5109), .sb(1.4e-07), .sa(1.4e-07))  \MXclkinv/Mmn0 ( \CKb#11 , \CK#2 , \VSS#6 , \VSS#3 );
  electrical \VSS#8 ;
  electrical y ;
  electrical \Qb#6 ;
  g45n1svt #( .l(4.5e-08), .w(1.45e-07), .ad(2.32e-14), .as(2.32e-14), .pd(5.9e-07), .ps(5.9e-07), .nrd(3.388E-01), .nrs(3.388E-01), .scc(2.1811e-05), .scb(0.00346364), .sca(6.59771), .sb(3.45e-07), .sa(1.4e-07))  Mmn3 ( \Qb#6 , y , \VSS#8 , \VSS#3 );
  electrical \CKb#6 ;
  electrical \y#7 ;
  g45n1svt #( .l(4.5e-08), .w(1.45e-07), .ad(2.03e-14), .as(2.03e-14), .pd(5.9e-07), .ps(5.9e-07), .nrd(3.388E-01), .nrs(3.388E-01), .scc(2.16281e-05), .scb(0.00316007), .sca(6.15549), .sb(1.4e-07), .sa(3.45e-07))  Mmn2 ( \y#7 , \CKb#6 , \VSS#8 , \VSS#3 );
  electrical \VSS#7 ;
  electrical \D#2 ;
  electrical a ;
  g45n1svt #( .l(4.5e-08), .w(1.45e-07), .ad(8.7e-15), .as(8.7e-15), .pd(4.9e-07), .ps(4.9e-07), .nrd(2.000E-01), .nrs(3.388E-01), .scc(2.18715e-05), .scb(0.00351544), .sca(6.65575), .sb(2.45e-07), .sa(1.4e-07))  Mmn1 ( a , \D#2 , \VSS#7 , \VSS#3 );
  electrical \CKb#7 ;
  electrical \x#3 ;
  g45n1svt #( .l(4.5e-08), .w(1.45e-07), .ad(2.03e-14), .as(2.03e-14), .pd(4.9e-07), .ps(4.9e-07), .nrd(3.388E-01), .nrs(2.000E-01), .scc(2.33598e-05), .scb(0.00413523), .sca(7.21705), .sb(1.4e-07), .sa(2.45e-07))  Mmn4 ( \x#3 , \CKb#7 , a , \VSS#3 );
  electrical \VSS#1 ;
  electrical Qb ;
  electrical \QQ#1 ;
  g45n1svt #( .l(4.5e-08), .w(2.6e-07), .ad(3.64e-14), .as(3.64e-14), .pd(8e-07), .ps(8e-07), .nrd(2.046E-01), .nrs(2.046E-01), .scc(0.00219352), .scb(0.027494), .sca(23.7936), .sb(1.4e-07), .sa(1.4e-07))  \MXqinv/Mmn0 ( \QQ#1 , Qb , \VSS#1 , \VSS#3 );
  electrical \VDD#3 ;
  electrical \VDD#6 ;
  electrical \CK#1 ;
  electrical \CKb#10 ;
  g45p1svt #( .l(4.5e-08), .w(2.15e-07), .ad(3.01e-14), .as(3.01e-14), .pd(7.1e-07), .ps(7.1e-07), .nrd(2.353E-01), .nrs(2.353E-01), .scc(0.00236439), .scb(0.030473), .sca(27.4166), .sb(1.4e-07), .sa(1.4e-07))  \MXclkinv/Mmp0 ( \CKb#10 , \CK#1 , \VDD#6 , \VDD#3 );
  electrical \VDD#8 ;
  electrical \y#3 ;
  electrical c ;
  g45p1svt #( .l(4.5e-08), .w(2.15e-07), .ad(1.29e-14), .as(1.29e-14), .pd(6.3e-07), .ps(6.3e-07), .nrd(1.349E-01), .nrs(2.353E-01), .scc(0.000100355), .scb(0.00880481), .sca(11.3805), .sb(2.45e-07), .sa(1.4e-07))  Mmp3 ( c , \y#3 , \VDD#8 , \VDD#3 );
  electrical \CKb#5 ;
  electrical \Qb#7 ;
  g45p1svt #( .l(4.5e-08), .w(2.15e-07), .ad(3.01e-14), .as(3.01e-14), .pd(6.3e-07), .ps(6.3e-07), .nrd(2.353E-01), .nrs(1.349E-01), .scc(9.87233e-05), .scb(0.00815874), .sca(10.8044), .sb(1.4e-07), .sa(2.45e-07))  Mmp5 ( \Qb#7 , \CKb#5 , c , \VDD#3 );
  electrical b ;
  electrical x ;
  electrical \y#6 ;
  g45p1svt #( .l(4.5e-08), .w(2.15e-07), .ad(1.29e-14), .as(1.29e-14), .pd(6.3e-07), .ps(6.3e-07), .nrd(2.353E-01), .nrs(1.349E-01), .scc(9.84553e-05), .scb(0.00778243), .sca(10.2794), .sb(4.5e-07), .sa(1.4e-07))  Mmp4 ( \y#6 , x , b , \VDD#3 );
  electrical \VDD#7 ;
  electrical CKb ;
  g45p1svt #( .l(4.5e-08), .w(2.15e-07), .ad(3.44e-14), .as(3.44e-14), .pd(6.5e-07), .ps(6.5e-07), .nrd(1.349E-01), .nrs(2.353E-01), .scc(9.84777e-05), .scb(0.00786563), .sca(10.4291), .sb(3.45e-07), .sa(2.45e-07))  Mmp2 ( b , CKb , \VDD#7 , \VDD#3 );
  electrical \D#1 ;
  electrical \x#5 ;
  g45p1svt #( .l(4.5e-08), .w(2.15e-07), .ad(3.01e-14), .as(3.01e-14), .pd(7.3e-07), .ps(7.3e-07), .nrd(2.353E-01), .nrs(2.353E-01), .scc(9.96516e-05), .scb(0.00859678), .sca(11.2136), .sb(1.4e-07), .sa(4.5e-07))  Mmp1 ( \x#5 , \D#1 , \VDD#7 , \VDD#3 );
  electrical \VDD#1 ;
  electrical \Qb#4 ;
  electrical \QQ#2 ;
  g45p1svt #( .l(4.5e-08), .w(3.9e-07), .ad(5.46e-14), .as(5.46e-14), .pd(1.06e-06), .ps(1.06e-06), .nrd(1.364E-01), .nrs(1.364E-01), .scc(0.00172236), .scb(0.0288355), .sca(24.7656), .sb(1.4e-07), .sa(1.4e-07))  \MXqinv/Mmp0 ( \QQ#2 , \Qb#4 , \VDD#1 , \VDD#3 );
  //
  //
  //        RESISTOR AND CAP/DIODE CARDS
  //
  resistor #(.r(280.3349)) Rl1 ( \CK#1 , \CK#2 );
  electrical \CK#3 ;
  resistor #(.r(93.7687)) Rl2 ( \CK#2 , \CK#3 );
  electrical \y#2 ;
  resistor #(.r(23.8263)) Rl3 ( y , \y#2 );
  resistor #(.r(236.2442)) Rl4 ( \y#2 , \y#3 );
  electrical \y#4 ;
  resistor #(.r(86.0764)) Rl5 ( \y#3 , \y#4 );
  electrical \y#5 ;
  resistor #(.r(50.7830)) Rl6 ( \y#2 , \y#5 );
  electrical \x#2 ;
  resistor #(.r(75.0021)) Rl7 ( x , \x#2 );
  electrical \CKb#2 ;
  resistor #(.r(156.5021)) Rl8 ( CKb , \CKb#2 );
  electrical \CKb#3 ;
  resistor #(.r(83.0817)) Rl9 ( \CKb#2 , \CKb#3 );
  electrical \CKb#4 ;
  resistor #(.r(124.2107)) Rl10 ( \CKb#3 , \CKb#4 );
  resistor #(.r(81.9251)) Rl11 ( \CKb#4 , \CKb#5 );
  resistor #(.r(84.2969)) Rl12 ( \CKb#3 , \CKb#6 );
  resistor #(.r(264.9503)) Rl13 ( \D#1 , \D#2 );
  resistor #(.r(87.9995)) Rl14 ( \D#2 , D );
  electrical \CKb#8 ;
  resistor #(.r(115.3867)) Rl15 ( \CKb#7 , \CKb#8 );
  electrical \Qb#2 ;
  resistor #(.r(138.6781)) Rl16 ( Qb , \Qb#2 );
  electrical \Qb#3 ;
  resistor #(.r(77.2400)) Rl17 ( \Qb#2 , \Qb#3 );
  resistor #(.r(67.0634)) Rl18 ( \Qb#2 , \Qb#4 );
  resistor #(.r(2.766E-02)) Rk1 ( CK , \CK#3 );
  electrical \CKb#9 ;
  resistor #(.r(45.2623)) Rk2 ( \CKb#4 , \CKb#9 );
  resistor #(.r(62.3479)) Rk3 ( \CKb#9 , \CKb#10 );
  resistor #(.r(75.3378)) Rk4 ( \CKb#9 , \CKb#11 );
  resistor #(.r(62.4760)) Rk5 ( \y#6 , \y#4 );
  resistor #(.r(75.3198)) Rk6 ( \y#7 , \y#5 );
  resistor #(.r(45.2235)) Rk8 ( \CKb#2 , \CKb#8 );
  electrical \Qb#5 ;
  resistor #(.r(0.5187)) Rk9 ( \Qb#3 , \Qb#5 );
  resistor #(.r(75.6279)) Rk10 ( \Qb#5 , \Qb#6 );
  resistor #(.r(62.3510)) Rk11 ( \Qb#5 , \Qb#7 );
  electrical \x#4 ;
  resistor #(.r(75.7518)) Rk12 ( \x#3 , \x#4 );
  resistor #(.r(0.3269)) Rk13 ( \x#4 , \x#2 );
  resistor #(.r(62.1660)) Rk14 ( \x#4 , \x#5 );
  resistor #(.r(38.1535)) Rk15 ( \QQ#1 , QQ );
  resistor #(.r(20.6667)) Rk16 ( QQ , \QQ#2 );
  electrical \VSS#2 ;
  resistor #(.r(38.0529)) Rk17 ( \VSS#1 , \VSS#2 );
  electrical \VSS#4 ;
  resistor #(.r(6.518E-02)) Rk18 ( \VSS#2 , \VSS#4 );
  electrical \VSS#5 ;
  resistor #(.r(9.787E-02)) Rk19 ( \VSS#4 , \VSS#5 );
  resistor #(.r(0.2941)) Rk20 ( \VSS#5 , VSS );
  resistor #(.r(75.3400)) Rk21 ( VSS , \VSS#6 );
  resistor #(.r(75.3056)) Rk22 ( \VSS#2 , \VSS#7 );
  resistor #(.r(75.2975)) Rk23 ( \VSS#5 , \VSS#8 );
  resistor #(.r(6.2000)) Rk24 ( \VSS#3 , \VSS#4 );
  electrical \VDD#2 ;
  resistor #(.r(21.1477)) Rk25 ( \VDD#1 , \VDD#2 );
  electrical \VDD#4 ;
  resistor #(.r(0.1482)) Rk26 ( \VDD#2 , \VDD#4 );
  electrical \VDD#5 ;
  resistor #(.r(0.3046)) Rk27 ( \VDD#4 , \VDD#5 );
  resistor #(.r(8.027E-02)) Rk28 ( \VDD#5 , VDD );
  resistor #(.r(62.3619)) Rk29 ( VDD , \VDD#6 );
  resistor #(.r(62.2792)) Rk30 ( \VDD#2 , \VDD#7 );
  resistor #(.r(62.3378)) Rk31 ( \VDD#5 , \VDD#8 );
  resistor #(.r(7.5000)) Rk32 ( \VDD#3 , \VDD#4 );
  //
  //        CAPACITOR CARDS
  //
  //
  capacitor #(.c(1.55925E-18)) C1 ( \CK#3 , \CKb#9 );
  capacitor #(.c(4.94932E-19)) C2 ( \x#4 , \D#2 );
  capacitor #(.c(3.08918E-17)) C3 ( \CKb#8 , \Qb#3 );
  capacitor #(.c(1.01191E-17)) C4 ( \y#2 , \VDD#3 );
  capacitor #(.c(4.60644E-18)) C5 ( \CKb#11 , \CK#2 );
  capacitor #(.c(1.83162E-18)) C6 ( VDD , \CK#1 );
  capacitor #(.c(1.05033E-17)) C7 ( \y#5 , \CKb#6 );
  capacitor #(.c(9.54615E-19)) C8 ( \y#6 , \CKb#5 );
  capacitor #(.c(3.91782E-17)) C9 ( \VDD#1 , \QQ#2 );
  capacitor #(.c(2.7303E-19)) C10 ( VDD , \CK#2 );
  capacitor #(.c(1.30843E-17)) C11 ( Qb , \VDD#3 );
  capacitor #(.c(5.92147E-19)) C12 ( VDD , \y#4 );
  capacitor #(.c(8.0994E-18)) C13 ( \Qb#7 , \y#4 );
  capacitor #(.c(4.86744E-19)) C14 ( \VSS#5 , \CKb#4 );
  capacitor #(.c(2.82404E-18)) C15 ( \Qb#7 , \CKb#5 );
  capacitor #(.c(7.04902E-18)) C16 ( \VSS#6 , \CK#2 );
  capacitor #(.c(4.27492E-18)) C17 ( \CKb#10 , VDD );
  capacitor #(.c(4.38007E-18)) C18 ( \y#6 , \VDD#2 );
  capacitor #(.c(1.22705E-17)) C19 ( \CKb#3 , \VDD#3 );
  capacitor #(.c(8.69563E-18)) C20 ( \CKb#2 , \Qb#3 );
  capacitor #(.c(4.073E-18)) C21 ( \CKb#7 , \VDD#3 );
  capacitor #(.c(2.10436E-18)) C22 ( \CKb#2 , \x#3 );
  capacitor #(.c(6.51143E-18)) C23 ( \CK#2 , \y#2 );
  capacitor #(.c(8.57032E-19)) C24 ( \VDD#8 , \CKb#5 );
  capacitor #(.c(3.05297E-18)) C25 ( \x#4 , \VDD#2 );
  capacitor #(.c(8.37451E-19)) C26 ( \Qb#7 , \y#3 );
  capacitor #(.c(1.0298E-18)) C27 ( \CKb#9 , \y#2 );
  capacitor #(.c(1.60288E-17)) C28 ( \Qb#2 , \VDD#3 );
  capacitor #(.c(6.6654E-19)) C29 ( \CKb#10 , \Qb#5 );
  capacitor #(.c(3.95753E-18)) C30 ( \Qb#3 , \x#2 );
  capacitor #(.c(2.14465E-17)) C31 ( \VDD#6 , \CKb#10 );
  capacitor #(.c(5.61849E-19)) C32 ( \VSS#3 , \Qb#5 );
  capacitor #(.c(1.34681E-17)) C33 ( \VSS#8 , \y#7 );
  capacitor #(.c(2.71625E-19)) C34 ( CK , \y#4 );
  capacitor #(.c(1.91692E-17)) C35 ( \x#5 , \VDD#1 );
  capacitor #(.c(7.24318E-18)) C36 ( \D#2 , \VDD#3 );
  capacitor #(.c(2.06439E-19)) C37 ( \VSS#2 , \CK#3 );
  capacitor #(.c(1.01542E-17)) C38 ( \VDD#8 , \y#4 );
  capacitor #(.c(4.90556E-18)) C39 ( CK , \VDD#3 );
  capacitor #(.c(1.26341E-18)) C40 ( \VSS#3 , \CKb#6 );
  capacitor #(.c(2.95778E-18)) C41 ( \QQ#1 , \Qb#2 );
  capacitor #(.c(2.90081E-18)) C42 ( \VDD#8 , \y#3 );
  capacitor #(.c(1.05658E-17)) C43 ( \CKb#9 , \VDD#3 );
  capacitor #(.c(1.4164E-18)) C44 ( \CK#3 , y );
  capacitor #(.c(1.64124E-17)) C45 ( \VSS#7 , \CKb#2 );
  capacitor #(.c(1.52586E-18)) C46 ( \x#4 , \Qb#4 );
  capacitor #(.c(2.20615E-17)) C47 ( \y#6 , \VDD#3 );
  capacitor #(.c(5.33441E-19)) C48 ( \VSS#5 , \CKb#6 );
  capacitor #(.c(1.70318E-18)) C49 ( \CKb#10 , \y#3 );
  capacitor #(.c(5.05984E-18)) C50 ( \CKb#6 , \VDD#3 );
  capacitor #(.c(1.61933E-18)) C51 ( \y#4 , \VDD#2 );
  capacitor #(.c(1.69736E-18)) C52 ( \Qb#5 , \y#2 );
  capacitor #(.c(4.71838E-18)) C53 ( \CKb#9 , \CK#2 );
  capacitor #(.c(3.02587E-18)) C54 ( \QQ#2 , \Qb#2 );
  capacitor #(.c(1.12588E-18)) C55 ( \D#1 , \Qb#2 );
  capacitor #(.c(6.01366E-19)) C56 ( \Qb#6 , \y#7 );
  capacitor #(.c(6.16742E-19)) C57 ( \y#7 , \CKb#2 );
  capacitor #(.c(6.54648E-18)) C58 ( \Qb#5 , \VDD#3 );
  capacitor #(.c(3.26084E-18)) C59 ( CK , \VSS#8 );
  capacitor #(.c(2.49171E-18)) C60 ( \VDD#8 , \CK#1 );
  capacitor #(.c(8.22158E-19)) C61 ( \Qb#7 , \VDD#3 );
  capacitor #(.c(1.07887E-17)) C62 ( CK , \CKb#11 );
  capacitor #(.c(8.27388E-19)) C63 ( \VDD#6 , \y#4 );
  capacitor #(.c(7.92866E-19)) C64 ( \VSS#5 , \CK#3 );
  capacitor #(.c(3.90197E-18)) C65 ( y , \VDD#3 );
  capacitor #(.c(5.90112E-18)) C66 ( \VSS#5 , \Qb#6 );
  capacitor #(.c(5.33159E-19)) C67 ( \VSS#1 , \Qb#2 );
  capacitor #(.c(4.48217E-19)) C68 ( \VSS#7 , \x#2 );
  capacitor #(.c(1.85918E-17)) C69 ( \VDD#7 , \x#5 );
  capacitor #(.c(4.1989E-18)) C70 ( \CKb#2 , \x#2 );
  capacitor #(.c(1.035E-18)) C71 ( \VDD#2 , \Qb#4 );
  capacitor #(.c(5.62394E-18)) C72 ( \D#1 , \Qb#4 );
  capacitor #(.c(4.38525E-18)) C73 ( \CKb#10 , \CK#1 );
  capacitor #(.c(2.0505E-18)) C74 ( CK , \CKb#9 );
  capacitor #(.c(6.89248E-18)) C75 ( \x#4 , \D#1 );
  capacitor #(.c(7.29925E-18)) C76 ( \x#4 , \VDD#3 );
  capacitor #(.c(1.06756E-17)) C77 ( \VSS#5 , CK );
  capacitor #(.c(1.50198E-18)) C78 ( \VSS#5 , y );
  capacitor #(.c(4.20225E-18)) C79 ( \VDD#6 , \CK#1 );
  capacitor #(.c(4.04658E-18)) C80 ( \Qb#5 , \CKb#3 );
  capacitor #(.c(3.37361E-17)) C81 ( \VDD#5 , \y#4 );
  capacitor #(.c(1.35071E-17)) C82 ( \Qb#6 , \VSS#8 );
  capacitor #(.c(1.16583E-18)) C83 ( \VDD#1 , \Qb#2 );
  capacitor #(.c(5.53817E-19)) C84 ( \y#7 , \x#2 );
  capacitor #(.c(2.33394E-17)) C85 ( \CK#2 , \VDD#3 );
  capacitor #(.c(1.86485E-17)) C86 ( CKb , \D#1 );
  capacitor #(.c(2.54681E-18)) C87 ( \Qb#6 , \CKb#2 );
  capacitor #(.c(3.38514E-18)) C88 ( \VSS#2 , \VDD#3 );
  capacitor #(.c(1.13163E-18)) C89 ( \x#3 , \Qb#2 );
  capacitor #(.c(4.83586E-18)) C90 ( \CKb#8 , \Qb#2 );
  capacitor #(.c(3.00735E-17)) C91 ( x , CKb );
  capacitor #(.c(1.38672E-17)) C92 ( \Qb#3 , \VDD#3 );
  capacitor #(.c(1.66889E-18)) C93 ( \VDD#2 , \D#1 );
  capacitor #(.c(6.18315E-19)) C94 ( \x#4 , CKb );
  capacitor #(.c(5.92887E-17)) C95 ( \Qb#3 , \x#4 );
  capacitor #(.c(1.55352E-17)) C96 ( \x#4 , \QQ#2 );
  capacitor #(.c(7.75185E-18)) C97 ( \x#4 , \QQ#1 );
  capacitor #(.c(5.48357E-18)) C98 ( \QQ#1 , Qb );
  capacitor #(.c(2.39762E-18)) C99 ( \CKb#4 , \x#2 );
  capacitor #(.c(3.29149E-18)) C100 ( \CKb#5 , x );
  capacitor #(.c(2.57249E-18)) C101 ( \CKb#10 , \VDD#3 );
  capacitor #(.c(2.80879E-17)) C102 ( \VSS#1 , \QQ#1 );
  capacitor #(.c(8.03985E-18)) C103 ( \CKb#8 , \VDD#3 );
  capacitor #(.c(9.07724E-18)) C104 ( \VSS#1 , Qb );
  capacitor #(.c(1.50452E-17)) C105 ( \VSS#8 , \y#5 );
  capacitor #(.c(7.657E-19)) C106 ( \VDD#1 , \Qb#3 );
  capacitor #(.c(1.356E-17)) C107 ( \y#6 , \VDD#7 );
  capacitor #(.c(2.80067E-18)) C108 ( \y#5 , \CKb#4 );
  capacitor #(.c(3.7217E-18)) C109 ( \VSS#5 , \VDD#3 );
  capacitor #(.c(3.13811E-17)) C110 ( \y#3 , \CKb#5 );
  capacitor #(.c(3.43823E-18)) C111 ( \x#3 , Qb );
  capacitor #(.c(2.44125E-18)) C112 ( \VDD#2 , CKb );
  capacitor #(.c(3.95557E-17)) C113 ( \CKb#11 , \Qb#6 );
  capacitor #(.c(1.33675E-18)) C114 ( \CKb#8 , \x#4 );
  capacitor #(.c(2.19581E-17)) C115 ( \x#4 , \VDD#1 );
  capacitor #(.c(7.95765E-18)) C116 ( \Qb#6 , \y#5 );
  capacitor #(.c(3.39733E-19)) C117 ( \VSS#3 , \CKb#2 );
  capacitor #(.c(4.83972E-18)) C118 ( \x#4 , \Qb#2 );
  capacitor #(.c(1.783E-17)) C119 ( \x#3 , \QQ#1 );
  capacitor #(.c(3.02793E-18)) C120 ( \CKb#9 , \Qb#5 );
  capacitor #(.c(9.97607E-19)) C121 ( \VSS#1 , \CKb#7 );
  capacitor #(.c(6.92042E-18)) C122 ( \CK#1 , \y#3 );
  capacitor #(.c(1.53042E-18)) C123 ( \VSS#2 , \CKb#8 );
  capacitor #(.c(1.53179E-17)) C124 ( \QQ#1 , \VDD#3 );
  capacitor #(.c(4.59614E-19)) C125 ( \VSS#7 , Qb );
  capacitor #(.c(1.26104E-17)) C126 ( \CKb#2 , \VDD#3 );
  capacitor #(.c(2.50576E-18)) C127 ( \x#3 , \CKb#7 );
  capacitor #(.c(1.19581E-18)) C128 ( \y#7 , \CKb#3 );
  capacitor #(.c(1.35603E-17)) C129 ( \Qb#3 , \D#1 );
  capacitor #(.c(4.15497E-18)) C130 ( \CKb#4 , \y#4 );
  capacitor #(.c(1.77277E-18)) C131 ( \VSS#5 , \y#2 );
  capacitor #(.c(2.63879E-17)) C132 ( \VSS#1 , \x#3 );
  capacitor #(.c(4.94093E-18)) C133 ( \Qb#6 , \CKb#4 );
  capacitor #(.c(4.13386E-18)) C134 ( \CKb#8 , \D#1 );
  capacitor #(.c(6.31923E-18)) C135 ( \VSS#1 , \VDD#3 );
  capacitor #(.c(2.06135E-18)) C136 ( \CKb#3 , \x#2 );
  capacitor #(.c(1.0234E-17)) C137 ( \x#2 , \VDD#3 );
  capacitor #(.c(1.0261E-18)) C138 ( \VSS#3 , \y#5 );
  capacitor #(.c(7.95948E-19)) C139 ( \VSS#7 , \CKb#7 );
  capacitor #(.c(1.25937E-18)) C140 ( \y#6 , \CKb#3 );
  capacitor #(.c(1.07815E-17)) C141 ( \CKb#2 , \D#1 );
  capacitor #(.c(2.71122E-18)) C142 ( \CKb#9 , \y#3 );
  capacitor #(.c(1.1564E-18)) C143 ( \x#3 , \D#2 );
  capacitor #(.c(8.95364E-19)) C144 ( \CK#1 , \y#2 );
  capacitor #(.c(1.5263E-17)) C145 ( \Qb#5 , \CKb#2 );
  capacitor #(.c(4.27679E-18)) C146 ( \x#3 , \VDD#3 );
  capacitor #(.c(4.33434E-18)) C147 ( \CKb#7 , Qb );
  capacitor #(.c(1.89697E-17)) C148 ( \Qb#7 , \y#6 );
  capacitor #(.c(4.88844E-19)) C149 ( \Qb#5 , \y#3 );
  capacitor #(.c(1.88049E-18)) C150 ( \y#5 , \VDD#3 );
  capacitor #(.c(6.21099E-18)) C151 ( \Qb#6 , \y#2 );
  capacitor #(.c(1.34681E-17)) C152 ( \VSS#6 , \CKb#11 );
  capacitor #(.c(3.35379E-18)) C153 ( \VSS#2 , \x#3 );
  capacitor #(.c(7.77477E-18)) C154 ( \x#4 , \VDD#7 );
  capacitor #(.c(1.39624E-17)) C155 ( \y#5 , \CKb#3 );
  capacitor #(.c(1.90295E-17)) C156 ( \x#2 , CKb );
  capacitor #(.c(2.7002E-18)) C157 ( \Qb#5 , \x#4 );
  capacitor #(.c(2.43294E-18)) C158 ( \VSS#7 , \D#2 );
  capacitor #(.c(5.42216E-19)) C159 ( \VSS#8 , \CK#3 );
  capacitor #(.c(2.62848E-18)) C160 ( \VSS#7 , \Qb#5 );
  capacitor #(.c(1.03554E-17)) C161 ( \CKb#4 , \VDD#3 );
  capacitor #(.c(2.48676E-17)) C162 ( \D#2 , \CKb#7 );
  capacitor #(.c(4.82247E-18)) C163 ( \CKb#9 , \CK#1 );
  capacitor #(.c(9.18065E-18)) C164 ( \Qb#4 , \VDD#3 );
  capacitor #(.c(5.53526E-18)) C165 ( \VSS#3 , \y#7 );
  capacitor #(.c(1.10657E-18)) C166 ( \VSS#2 , \CKb#2 );
  capacitor #(.c(2.30203E-17)) C167 ( \y#2 , \CKb#4 );
  capacitor #(.c(3.74613E-17)) C168 ( \Qb#5 , \x#2 );
  capacitor #(.c(5.8161E-18)) C169 ( \QQ#2 , \Qb#4 );
  capacitor #(.c(9.35495E-19)) C170 ( \VDD#5 , \CKb#5 );
  capacitor #(.c(6.87092E-19)) C171 ( \CKb#11 , \y#2 );
  capacitor #(.c(3.71921E-18)) C172 ( \VSS#7 , \VDD#3 );
  capacitor #(.c(1.13576E-17)) C173 ( \VDD#1 , \Qb#4 );
  capacitor #(.c(2.649E-17)) C174 ( \y#4 , \VDD#3 );
  capacitor #(.c(1.20046E-17)) C175 ( \D#1 , \VDD#3 );
  capacitor #(.c(1.24617E-18)) C176 ( \VSS#7 , \CKb#6 );
  capacitor #(.c(3.30592E-18)) C177 ( \CKb#6 , \D#2 );
  capacitor #(.c(9.44587E-19)) C178 ( \x#5 , \Qb#4 );
  capacitor #(.c(1.73972E-18)) C179 ( \VDD#8 , \y#6 );
  capacitor #(.c(1.84582E-18)) C180 ( \CKb#5 , \x#2 );
  capacitor #(.c(9.71094E-19)) C181 ( \CKb#11 , \CK#3 );
  capacitor #(.c(6.80982E-18)) C182 ( \y#7 , \Qb#5 );
  capacitor #(.c(1.40549E-18)) C183 ( \y#7 , \VDD#3 );
  capacitor #(.c(8.12809E-18)) C184 ( \VSS#7 , \x#3 );
  capacitor #(.c(1.52756E-18)) C185 ( \y#7 , \CKb#6 );
  capacitor #(.c(7.31295E-18)) C186 ( \Qb#5 , \y#6 );
  capacitor #(.c(1.58313E-18)) C187 ( \VDD#1 , \D#1 );
  capacitor #(.c(1.1389E-17)) C188 ( \CK#3 , \VDD#3 );
  capacitor #(.c(6.15489E-18)) C189 ( \x#5 , \VDD#2 );
  capacitor #(.c(2.01825E-17)) C190 ( \y#5 , \Qb#5 );
  capacitor #(.c(1.40869E-18)) C191 ( \CKb#8 , Qb );
  capacitor #(.c(5.81435E-18)) C192 ( CKb , \VDD#3 );
  capacitor #(.c(1.7358E-18)) C193 ( \x#5 , \D#1 );
  capacitor #(.c(2.15836E-18)) C194 ( \VSS#8 , \CKb#6 );
  capacitor #(.c(8.84275E-18)) C195 ( y , \CKb#6 );
  capacitor #(.c(1.11053E-17)) C196 ( \VDD#8 , \Qb#7 );
  capacitor #(.c(1.11189E-17)) C197 ( \VSS#6 , \CK#3 );
  capacitor #(.c(2.68507E-18)) C198 ( \VDD#7 , \D#1 );
  capacitor #(.c(1.04608E-17)) C199 ( \y#4 , \CKb#5 );
  capacitor #(.c(1.35433E-18)) C200 ( \VSS#8 , \VDD#3 );
  capacitor #(.c(8.6918E-18)) C201 ( \x#2 , \y#6 );
  capacitor #(.c(6.42297E-19)) C202 ( \Qb#6 , \CKb#6 );
  capacitor #(.c(5.22082E-18)) C203 ( x , \VDD#3 );
  capacitor #(.c(2.12455E-17)) C204 ( \CKb#4 , \y#3 );
  capacitor #(.c(3.37313E-18)) C205 ( \y#7 , \x#3 );
  capacitor #(.c(6.22751E-19)) C206 ( \VSS#1 , \Qb#3 );
  capacitor #(.c(5.94285E-19)) C207 ( \x#5 , CKb );
  capacitor #(.c(2.49436E-17)) C208 ( \CKb#9 , \Qb#6 );
  capacitor #(.c(2.11197E-17)) C209 ( \CKb#8 , \D#2 );
  capacitor #(.c(1.8597E-18)) C210 ( \CKb#10 , \Qb#7 );
  capacitor #(.c(3.65592E-18)) C211 ( \Qb#6 , \VDD#3 );
  capacitor #(.c(7.05978E-19)) C212 ( \Qb#7 , \x#2 );
  capacitor #(.c(2.34988E-18)) C213 ( \VDD#7 , CKb );
  capacitor #(.c(2.3856E-18)) C214 ( \CK#2 , y );
  capacitor #(.c(4.70974E-17)) C215 ( \Qb#5 , \CKb#4 );
  capacitor #(.c(2.14711E-18)) C216 ( \VSS#8 , y );
  capacitor #(.c(5.92692E-19)) C217 ( \CKb#3 , \D#2 );
  capacitor #(.c(7.1372E-18)) C218 ( \x#3 , \Qb#3 );
  capacitor #(.c(7.3019E-18)) C219 ( \CKb#5 , \VDD#3 );
  capacitor #(.c(2.17562E-18)) C220 ( \CK#1 , \y#4 );
  capacitor #(.c(1.84078E-18)) C221 ( \x#2 , \VDD#2 );
  capacitor #(.c(1.77192E-18)) C222 ( \Qb#6 , y );
  capacitor #(.c(6.41862E-19)) C223 ( \D#2 , \Qb#2 );
  capacitor #(.c(1.02325E-18)) C224 ( \y#6 , CKb );
  capacitor #(.c(2.16939E-18)) C225 ( \CKb#9 , \y#4 );
  capacitor #(.c(4.27715E-18)) C226 ( \CKb#11 , \VDD#3 );
  capacitor #(.c(1.14664E-18)) C227 ( \Qb#7 , \x#4 );
  capacitor #(.c(1.17655E-18)) C228 ( \VSS#5 , \Qb#5 );
  capacitor #(.c(1.94921E-17)) C229 ( \CKb#2 , \D#2 );
  capacitor #(.c(8.3698E-19)) C230 ( \VDD#7 , x );
  capacitor #(.c(8.85329E-18)) C231 ( \QQ#2 , \VDD#3 );
  capacitor #(.c(2.58105E-18)) C232 ( \y#2 , \CKb#6 );
  capacitor #(.c(9.04623E-18)) C233 ( \y#3 , \VDD#3 );
  capacitor #(.c(1.12033E-18)) C234 ( \VSS#2 , \CKb#7 );
  capacitor #(.c(1.05415E-18)) C235 ( \y#2 , \CKb#3 );
  capacitor #(.c(2.75128E-19)) C236 ( \VSS#8 , \CK#2 );
  capacitor #(.c(1.70023E-17)) C237 ( \x#3 , \CKb#8 );
  capacitor #(.c(2.52133E-18)) C238 ( \VSS#5 , \y#5 );
  capacitor #(.c(5.86149E-18)) C239 ( \VSS#6 , \VDD#3 );
  capacitor #(.c(3.50673E-18)) C240 ( \y#6 , x );
  capacitor #(.c(1.13148E-17)) C241 ( \CKb#9 , \VDD#8 );
  capacitor #(.c(4.34963E-19)) C242 ( \VSS#6 , y );
  capacitor #(.c(3.11896E-17)) C243 ( \y#7 , \VSS#7 );
  capacitor #(.c(2.25627E-17)) C244 ( \CK#1 , \VDD#3 );
  capacitor #(.c(1.00949E-18)) C245 ( \Qb#7 , x );
  capacitor #(.c(2.55809E-17)) C246 ( \CKb#10 , \VDD#8 );
  capacitor #(.c(3.1782E-17)) C247 ( \VSS#2 , D );
  capacitor #(.c(2.82486E-18)) C248 ( D , Qb );
  capacitor #(.c(3.59734E-19)) C249 ( \VSS#8 , D );
  capacitor #(.c(8.59983E-18)) C250 ( D , \VSS#1 );
  capacitor #(.c(1.24745E-17)) C251 ( D , \VDD#3 );
  capacitor #(.c(2.0252E-18)) C252 ( D , \CKb#6 );
  capacitor #(.c(1.32108E-17)) C253 ( \VSS#7 , D );
  capacitor #(.c(9.62496E-18)) C254 ( D , \CKb#7 );
  capacitor #(.c(2.55145E-18)) C255 ( D , \CKb#2 );
  capacitor #(.c(4.57608E-19)) C256 ( \VSS#5 , D );
  capacitor #(.c(2.47052E-18)) C257 ( D , \CKb#8 );
  capacitor #(.c(1.33477E-19)) C258 ( \VSS#2 , \D#1 );
  capacitor #(.c(3.85645E-19)) C259 ( \VDD#8 , x );
  capacitor #(.c(4.41406E-19)) C260 ( \VDD#2 , \Qb#3 );
  capacitor #(.c(2.84789E-19)) C261 ( \VDD#7 , \CKb#5 );
  capacitor #(.c(4.85143E-19)) C262 ( \CKb#9 , \VDD#5 );
  capacitor #(.c(1.63839E-19)) C263 ( \CKb#10 , \x#2 );
  capacitor #(.c(1.6968E-19)) C264 ( \x#3 , \CKb#3 );
  capacitor #(.c(2.76567E-19)) C265 ( \x#4 , \CKb#4 );
  capacitor #(.c(4.08321E-19)) C266 ( \x#3 , \CKb#6 );
  capacitor #(.c(4.06852E-19)) C267 ( \y#7 , Qb );
  capacitor #(.c(4.30401E-19)) C268 ( \y#4 , \Qb#4 );
  capacitor #(.c(1.7456E-19)) C269 ( \VSS#3 , \CKb#3 );
  capacitor #(.c(1.98576E-19)) C270 ( \VSS#6 , \CKb#6 );
  capacitor #(.c(2.13784E-19)) C271 ( \VSS#8 , \CKb#3 );
  capacitor #(.c(2.21643E-19)) C272 ( \Qb#5 , CKb );
  capacitor #(.c(2.48552E-19)) C273 ( \CKb#2 , Qb );
  capacitor #(.c(3.1228E-19)) C274 ( \Qb#5 , \CKb#5 );
  capacitor #(.c(9.2257E-20)) C275 ( \y#5 , \CK#2 );
  capacitor #(.c(1.37498E-19)) C276 ( \Qb#7 , \D#1 );
  capacitor #(.c(1.44789E-19)) C277 ( \Qb#3 , D );
  capacitor #(.c(2.24774E-19)) C278 ( \Qb#5 , \D#2 );
  capacitor #(.c(2.24624E-19)) C279 ( \CKb#2 , \y#5 );
  capacitor #(.c(2.33011E-19)) C280 ( \CKb#11 , y );
  capacitor #(.c(2.60551E-19)) C281 ( \y#7 , \CKb#8 );
  capacitor #(.c(1.47273E-17)) C282 ( CK , VSS );
  capacitor #(.c(1.32425E-18)) C283 ( D , VSS );
  capacitor #(.c(1.61818E-19)) C284 ( a , VSS );
  capacitor #(.c(4.47876E-19)) C285 ( b , VSS );
  capacitor #(.c(4.3593E-19)) C286 ( c , VSS );
  capacitor #(.c(5.4082E-19)) C287 ( \Qb#4 , VSS );
  capacitor #(.c(1.04608E-18)) C288 ( \D#1 , VSS );
  capacitor #(.c(6.20423E-19)) C289 ( CKb , VSS );
  capacitor #(.c(3.57299E-19)) C290 ( x , VSS );
  capacitor #(.c(3.34645E-19)) C291 ( \CKb#5 , VSS );
  capacitor #(.c(3.69084E-19)) C292 ( \y#3 , VSS );
  capacitor #(.c(1.34988E-18)) C293 ( \CK#1 , VSS );
  capacitor #(.c(1.71327E-19)) C294 ( Qb , VSS );
  capacitor #(.c(5.83996E-19)) C295 ( \CKb#7 , VSS );
  capacitor #(.c(1.8764E-18)) C296 ( \D#2 , VSS );
  capacitor #(.c(6.99772E-20)) C297 ( \CKb#6 , VSS );
  capacitor #(.c(2.62975E-19)) C298 ( y , VSS );
  capacitor #(.c(1.37347E-18)) C299 ( \CK#2 , VSS );
  capacitor #(.c(7.14856E-20)) C300 ( \Qb#3 , VSS );
  capacitor #(.c(5.96994E-19)) C301 ( \CKb#8 , VSS );
  capacitor #(.c(2.83053E-19)) C302 ( \CKb#2 , VSS );
  capacitor #(.c(3.3787E-19)) C303 ( \x#2 , VSS );
  capacitor #(.c(6.04247E-19)) C304 ( \y#4 , VSS );
  capacitor #(.c(2.47691E-17)) C305 ( \CK#3 , VSS );
  capacitor #(.c(7.10883E-18)) C306 ( \VDD#3 , VSS );
  capacitor #(.c(1.72634E-19)) C307 ( \QQ#2 , VSS );
  capacitor #(.c(4.56092E-19)) C308 ( \VDD#1 , VSS );
  capacitor #(.c(7.45468E-20)) C309 ( \x#5 , VSS );
  capacitor #(.c(4.74766E-19)) C310 ( \VDD#7 , VSS );
  capacitor #(.c(9.81109E-19)) C311 ( \y#6 , VSS );
  capacitor #(.c(7.85198E-19)) C312 ( \Qb#7 , VSS );
  capacitor #(.c(1.66868E-19)) C313 ( \VDD#8 , VSS );
  capacitor #(.c(2.10828E-19)) C314 ( \CKb#10 , VSS );
  capacitor #(.c(1.45146E-19)) C315 ( \VDD#6 , VSS );
  capacitor #(.c(8.82983E-19)) C316 ( \QQ#1 , VSS );
  capacitor #(.c(1.72574E-18)) C317 ( \y#7 , VSS );
  capacitor #(.c(1.51769E-18)) C318 ( \Qb#6 , VSS );
  capacitor #(.c(1.58591E-19)) C319 ( \y#2 , VSS );
  capacitor #(.c(2.61707E-19)) C320 ( \CKb#3 , VSS );
  capacitor #(.c(6.55779E-20)) C321 ( \Qb#2 , VSS );
  capacitor #(.c(1.55602E-18)) C322 ( \CKb#9 , VSS );
  capacitor #(.c(1.00669E-18)) C323 ( \Qb#5 , VSS );
  capacitor #(.c(2.23203E-19)) C324 ( \x#4 , VSS );
  capacitor #(.c(2.34777E-19)) C325 ( \VDD#2 , VSS );
  capacitor #(.c(2.19091E-19)) C326 ( \VDD#5 , VSS );
  //
  //
endmodule

//
