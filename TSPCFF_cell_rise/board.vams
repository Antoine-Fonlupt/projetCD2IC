// This module is a kind of test board fot the device under test (DUT)
// This module is written in "Verilog-AMS" language
//
// it's function is :
// - to generate electrical signals for the DUT
// - to extract measurements
// - to send measurements to the digital testbench

`timescale 1ns/100fs

// Mandatory for  AMS
`include "constants.vams"
`include "disciplines.vams"

// The board
module board(
                        // From the testbench
                        clk_logic          , // Clock input
                        din_logic          , // A logic signal generated by the testbench, and used to generate an input to the invertor
                        load_capacitor_val , // The expected value of a load capacitor loading the output of the invertor
                        din_tt_val         ,
                        clk_tt_val         , // Clock Transition Time
                        din_delay_val          , // An arbitrary incremental delay added to the input transition
                        clk_delay_val ,
                        // To the testbench
                        propagation_time,     // The measured output transition time for a falling output
                        dout_electrical     // The output of the  dut
                        ) ;

// IO defs
input   clk_logic          ;
input   clk_tt_val         ;
input   din_logic          ; // A logic signal generated by the testbench, and used to generate an input to the invertor
input   load_capacitor_val ; // The expected value of a load capacitor loading the output of the invertor
input   din_tt_val             ; // The expected value of the transition time of the input
input   clk_delay_val ;
input   din_delay_val          ; // An arbitrary incremental delay added to the input transition
output  propagation_time   ; // The measured output transition time for a falling output
output  dout_electrical    ; // Output signal of the invertor (used only to check the result of the simulation

// Nature of the signal
wire  clk_logic          ;
wire  din_logic          ; // A logic signal generated by the testbench, and used to generate an input to the invertor
wreal load_capacitor_val ; // The expected value of a load capacitor loading the output of the invertor
wreal clk_tt_val         ;
wreal din_tt_val         ; // The expected value of the transition time of the input
wreal clk_delay_val ;
wreal din_delay_val          ; // An arbitrary incremental delay added to the input transition
wreal propagation_time    ; // The measured output transition time for a falling output
electrical dout_electrical    ; // Output signal of the invertor

// Static parameters for the characterization
parameter real  power_voltage = 1.1 ; // volts
parameter real  slew_lower_threshold_pct 	= 0.3 ; // Fraction of the full swing
parameter real  slew_upper_threshold_pct 	= 0.7 ; // Fraction of the full swing
localparam real  input_threshold_pct      	= 0.5 ; // Fraction of the full swing
localparam real  output_threshold_pct      	= 0.5 ; // Fraction of the full swing

///////////////////////////////////////////////////////////////
// The analog world...
///////////////////////////////////////////////////////////////

// Internal Signals
electrical din_electrical     ; // Input signal of the invertor
electrical clk_electrical ;

// nodes for power supplies
electrical vss          ; // The ground reference
ground vss              ; // This is a global ground associated to the node "0" of the electrical simulator
electrical vdd          ; // Power supply of the device under test
electrical tmp ;

// Branches for power supplies, passive dipoles...
branch (vdd,vss) power_dut                ; //  The power supply branch is named power_dut
branch (dout_electrical,vss) load_capacitor   ; //  The passive branch for the load capacitor
branch (tmp,vss) tmp_val;

// Equations for the branches
analog
begin
 // The power_dut branch is an ideal voltage source
 V(power_dut) <+ power_voltage ;
 // The load_capacitor branch is an ideal capacitor
 // Smooth the capacitor update in order to limit simulator convergence problems
 I(load_capacitor) <+ ddt(V(load_capacitor))*transition(load_capacitor_val,0,1p,1p);

 //I(load_capacitor) <+ ddt(V(load_capacitor))*load_capacitor_val ;
end

// Here we generate the input transition using the variables transmitted by the testbench
cmos_transition cmos_tr(.din(din_logic),
                        .dout(din_electrical),
                        .tt_val(din_tt_val),
                        .delay_val(din_delay_val)) ;

cmos_transition cmos_clk_tr(.din(clk_logic),
                           .dout(clk_electrical),
                           .tt_val(clk_tt_val),
                           .delay_val(clk_delay_val)) ;

// The device under test is simply connected to the signals.
// All gates from the gsclib045 may be used in this netlist.
TSPCFF dut (.CK(clk_electrical), .D(din_electrical), .QQ(dout_electrical), .VDD(vdd), .VSS(vss)); //QQ is not a mistake

///////////////////////////////////////////////////////////////
// The measurements
///////////////////////////////////////////////////////////////

///////////////////////////////////////////////////////////////
// Propagation time for a falling output
///////////////////////////////////////////////////////////////

real t_input_above_input_threshold_pct ;
real t_output_above_output_threshold_pct  ;

always @(cross(V(clk_electrical)-power_voltage*input_threshold_pct, 1,1e-15,1e-4 ))
   t_input_above_input_threshold_pct = $abstime ;

always @(cross(V(dout_electrical)-power_voltage*output_threshold_pct, 1,1e-15,1e-4 ))
   t_output_above_output_threshold_pct = $abstime ;

assign propagation_time = t_output_above_output_threshold_pct - t_input_above_input_threshold_pct ;

endmodule
