ADE simulation setup
Run mode: Single Run, Sweeps and Corners
Tests:
  TSPCFF_LIB:TB_TSPCFF:1: TSPCFF_LIB/TB_TSPCFF/schematic, simulator spectre
Global variables (all switched off):
  tsetup = 150p
  wmp5 = 200n
  wmn2 = 300n
  wmn4 = wmn2
  wmp2 = wmp5
Corners (nominal off):
  C0 (off): tsetup={From/To}Auto:700p:20:200p{From/To}
  C1: wmn2={From/To}Auto:180n:20:300n{From/To}; wmp5={From/To}Auto:250n:20:350n{From/To}
