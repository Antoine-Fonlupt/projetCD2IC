//*** amscb_ie_crules.vams ***
//* connect rules file for AMSCB IE card
//* This file is automatically generated.

//* (c) Copyright 2007-2010 Cadence Design Systems, Inc.
//* All rights reserved.

`include "disciplines.vams"

// using connectrule: CR_dynsup_full_fast
discipline ddiscrete_dynsup_full_fast
  domain discrete;
enddiscipline

`define vsupmin 0.5
`define tr 2e-11
`define rout 200
`define vddnet "testbench.bdut.vdd"
`define vssnet "testbench.bdut.vss"
`define vlo 0
`define vhi 1
`define vthi `vlo+(`vhi-(`vlo))*2.0/3.0
`define vtlo `vlo+(`vhi-(`vlo))/3.0
`define vx 0
`define vtol (`vthi-(`vtlo))/4.0
`define tf `tr
`define txdel (`tr)*4.0
`define tdeltran 0
`define ttoltran (`tr)/10.0
`define ttolcross (`tr)/4.0
`define rlo `rout
`define rhi `rout
`define rx `rout
`define rz 10M
`define vdelta 25m
`define vtoldelta 1u
`define ttoldelta (`tr)/20.0
`define vpso 0.2
`define rsupply 4
`define rpull 1.5e3
`define rlarge 9.0e3
`define rweak 5.5e4
`define rmedium 3.2e5
`define rsmall 1.9e6
`define nox 0
`define debug 0
`define vss 0
`define vsup 1.8
`define vinlimit `vss+`vsup*4.0/3.0
`define vddlimit `vss+`vsup*4.0/3.0
`define vsup_low_output_x 0
`define currentmode 0
`define vmax 1.8
`define vmin 0
`define clamp 0
`define rin 2k
`define idelta (`vdelta)/(`rin)
`define itoldelta (`idelta)/4.0
`define ix 0
`define vbias `vmin+(`vmax)/2.0
`define dvclamp (`vmax)/20.0

connectrules ddiscrete_dynsup_full_fast_cr;
connect Bidir_2_dynsup  #( .vsup_min(`vsupmin), .vthi(`vthi), .vtlo(`vtlo), .vtol(`vtol), .vx(`vx), .tr(`tr), .tf(`tf), .ttol_t(`ttoltran), .tdelay(`tdeltran), .txdel(`txdel), .ttol_c(`ttolcross), .rhi(`rhi), .rlo(`rlo), .rx(`rx), .rz(`rz), .nox(`nox), .vsup_low_output_x(`vsup_low_output_x), .debug(`debug), .vinlimit(`vinlimit), .vddlimit(`vddlimit), .r_SUPPLY(`rsupply), .r_PULL(`rpull), .r_LARGE(`rlarge), .r_WEAK(`rweak), .r_MEDIUM(`rmedium), .r_SMALL(`rsmall), .vddnet(`vddnet), .vssnet(`vssnet) )ddiscrete_dynsup_full_fast, electrical;
connect E2L_2_dynsup  #( .vsup_min(`vsupmin), .vthi(`vthi), .vtlo(`vtlo), .vtol(`vtol), .tr(`tr), .tf(`tf), .ttol_t(`ttoltran), .tdelay(`tdeltran), .nox(`nox), .vsup_low_output_x(`vsup_low_output_x), .debug(`debug), .vinlimit(`vinlimit), .vddlimit(`vddlimit), .txdel(`txdel), .ttol_c(`ttolcross), .vddnet(`vddnet), .vssnet(`vssnet) )ddiscrete_dynsup_full_fast, electrical;
connect E2R  #( .vdelta(`vdelta), .vtol(`vtoldelta), .ttol(`ttoldelta), .vss(0), .vsup(`vmax), .currentmode(`currentmode), .idelta(`idelta), .itol(`itoldelta), .vbias(`vbias), .rin(`rin) )ddiscrete_dynsup_full_fast, electrical;
connect ER_bidir  #( .vdelta(`vdelta), .vtol(`vtoldelta), .ttol(`ttoldelta), .tr(`ttoldelta), .tf(`ttoldelta), .tdelay(`tdeltran), .rout(`rout), .rz(`rz), .vsup(`vmax), .currentmode(`currentmode), .idelta(`idelta), .itol(`itoldelta), .vbias(`vbias), .rin(`rin), .clamp(`clamp), .dvclamp(`dvclamp), .ix(`ix) )ddiscrete_dynsup_full_fast, electrical;
connect L2E_2_dynsup  #( .vthi(`vthi), .vtlo(`vtlo), .vx(`vx), .tr(`tr), .tf(`tf), .ttol_t(`ttoltran), .tdelay(`tdeltran), .rhi(`rhi), .rlo(`rlo), .rx(`rx), .rz(`rz), .debug(`debug), .vinlimit(`vinlimit), .vddlimit(`vddlimit), .r_SUPPLY(`rsupply), .r_PULL(`rpull), .r_LARGE(`rlarge), .r_WEAK(`rweak), .r_MEDIUM(`rmedium), .r_SMALL(`rsmall), .vddnet(`vddnet), .vssnet(`vssnet) )ddiscrete_dynsup_full_fast, electrical;
connect L2R_dig_dynsup  #( .vsup_min(`vsupmin), .vddnet(`vddnet), .vssnet(`vssnet) )ddiscrete_dynsup_full_fast, ddiscrete_dynsup_full_fast;
connect L2R_dynsup  #( .vsup_min(`vsupmin), .vddnet(`vddnet), .vssnet(`vssnet) )ddiscrete_dynsup_full_fast, ddiscrete_dynsup_full_fast;
connect R2E_2  #( .vsup(`vmax), .vdelta(`vdelta), .vss(0), .vx(`vx), .tr(`ttoldelta), .tf(`ttoldelta), .tdelay(`tdeltran), .rout(`rout), .rx(`rx), .rz(`rz), .currentmode(`currentmode), .idelta(`idelta), .clamp(`clamp), .dvclamp(`dvclamp), .ix(`ix) )ddiscrete_dynsup_full_fast, electrical;
connect R2L_dig_dynsup  #( .vsup_min(`vsupmin), .vthi(`vthi), .vtlo(`vtlo), .vddnet(`vddnet), .vssnet(`vssnet) )ddiscrete_dynsup_full_fast, ddiscrete_dynsup_full_fast;
connect R2L_dynsup  #( .vsup_min(`vsupmin), .vthi(`vthi), .vtlo(`vtlo), .vddnet(`vddnet), .vssnet(`vssnet) )ddiscrete_dynsup_full_fast, ddiscrete_dynsup_full_fast;
connect RL_bidir_dig_dynsup  #( .vsup_min(`vsupmin), .vthi(`vthi), .vtlo(`vtlo),.vddnet(`vddnet), .vssnet(`vssnet) )ddiscrete_dynsup_full_fast, ddiscrete_dynsup_full_fast;
connect RL_bidir_dynsup  #( .vsup_min(`vsupmin), .vthi(`vthi), .vtlo(`vtlo),.vddnet(`vddnet), .vssnet(`vssnet) )ddiscrete_dynsup_full_fast, ddiscrete_dynsup_full_fast;
endconnectrules
